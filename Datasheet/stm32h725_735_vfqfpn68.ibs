| IBIS file stm32h725_735_vfqfpn68.ibs
[IBIS ver] 4.2
[File name] stm32h725_735_vfqfpn68.ibs
[File Rev] rev2.1
[Date]  06-03-2024
[Source] Data Created at STMicroelectronics
[Notes]  File originated from ELDO simulations.
[Disclaimer]  This information is for modeling purpose only and is
   not guaranteed. The information is subject to change without
   notice.
[Copyright] Copyright 2024 STMicroelectronics Inc.
|   Component stm32h725_735_vfqfpn68
[Component] stm32h725_735_vfqfpn68
[Manufacturer] STMicroelectronics
[Package]
| variable   typ   min   max
R_pkg  0 0 0
L_pkg  0 0 0
C_pkg  0 0 0
[Pin]   signal_name   model_name   R_pin   L_pin   C_pin   | Comment
1 VBAT power
2 PC14-OSC32_IN io8_ft
3 PC15-OSC32_OUT io8_ft
4 VSSSMPS gnd
5 VLXSMPS nc
6 VDDSMPS power
7 VFBSMPS nc
8 VSS gnd
9 VDD power
10 PH0-OSC_IN io8_ft
11 PH1-OSC_OUT io8_ft
12 NRST ioreset_ft
13 PC0 io8_hslv_ft
14 PC1 io8_hslv_ft
15 VSSA gnd
16 VDDA power
17 PA0 io8_hslv_ft
18 PA1 io8_hslv_ft
19 PA2 io8_hslv_ft
20 PA3 io8_hslv_ft
21 VSS gnd
22 VDD power
23 PA4 io8_hslv_ft
24 PA5 io8_hslv_ft
25 PA6 io8_hslv_ft
26 PA7 io8_hslv_ft
27 PC4 io8_hslv_ft
28 PC5 io8_hslv_ft
29 PB0 io8_hslv_ft
30 PB1 io8_hslv_ft
31 PB2 io8_hslv_ft
32 PB10 io8_hslv_i2c_ft
33 VCAP power
34 VSS gnd
35 VDD power
36 PB12 io8_hslv_ft
37 PB13 io8_hslv_ft
38 PB14 io8_hslv_ft
39 PB15 io8_hslv_ft
40 PC6 io8_hslv_swp_ft
41 PC7 io8_hslv_ft
42 PC9 io8_hslv_i2c_ft
43 PA8 io8_hslv_i2c_ft
44 PA9 io8usb_vbus_otg20_ft
45 PA10 io8usb_id_otg20_ft
46 PA11 io8usb_lsfs_bcd_otg20_ft
47 PA12 io8usb_lsfs_bcd_otg20_ft
48 PA13 io8_ft
49 VCAP power
50 VSS gnd
51 VDD power
52 PA14 io8_ft
53 PA15 io8_ft
54 PC10 io8_hslv_i2c_ft
55 PC11 io8_hslv_i2c_ft
56 PC12 io8_hslv_ft
57 PD2 io8_hslv_ft
58 PB3 io8_hslv_ft
59 PB4 io8_hslv_ft
60 PB5 io8_hslv_ft
61 PB6 io8_hslv_i2c_ft
62 PB7 io8_i2c_ft
63 BOOT0 vpp_test_hv
64 PB8 io8_hslv_i2c_ft
65 PB9 io8_hslv_i2c_ft
66 VCAP power
67 VSS gnd
68 VDD power
[Model Selector] io8_ft
io8_ft_hs_1v2  "General purpose IO. 5V tolerant. 1.2V range. High speed."
io8_ft_hs_1v8  "General purpose IO. 5V tolerant. 1.8V range. High speed."
io8_ft_hs_3v3  "General purpose IO. 5V tolerant. 3.3V range. High speed."
io8_ft_fs_1v2  "General purpose IO. 5V tolerant. 1.2V range. Fast speed."
io8_ft_fs_1v8  "General purpose IO. 5V tolerant. 1.8V range. Fast speed."
io8_ft_fs_3v3  "General purpose IO. 5V tolerant. 3.3V range. Fast speed."
io8_ft_ms_1v2  "General purpose IO. 5V tolerant. 1.2V range. Medium speed."
io8_ft_ms_1v8  "General purpose IO. 5V tolerant. 1.8V range. Medium speed."
io8_ft_ms_3v3  "General purpose IO. 5V tolerant. 3.3V range. Medium speed."
io8_ft_ls_1v2  "General purpose IO. 5V tolerant. 1.2V range. Low speed."
io8_ft_ls_1v8  "General purpose IO. 5V tolerant. 1.8V range. Low speed."
io8_ft_ls_3v3  "General purpose IO. 5V tolerant. 3.3V range. Low speed."
[Model Selector] io8_hslv_ft
io8_ft_hs_1v2  "General purpose IO. 5V tolerant. 1.2V range. High speed."
io8_ft_hs_1v8  "General purpose IO. 5V tolerant. 1.8V range. High speed."
io8_ft_hs_3v3  "General purpose IO. 5V tolerant. 3.3V range. High speed."
io8_ft_fs_1v2  "General purpose IO. 5V tolerant. 1.2V range. Fast speed."
io8_ft_fs_1v8  "General purpose IO. 5V tolerant. 1.8V range. Fast speed."
io8_ft_fs_3v3  "General purpose IO. 5V tolerant. 3.3V range. Fast speed."
io8_ft_ms_1v2  "General purpose IO. 5V tolerant. 1.2V range. Medium speed."
io8_ft_ms_1v8  "General purpose IO. 5V tolerant. 1.8V range. Medium speed."
io8_ft_ms_3v3  "General purpose IO. 5V tolerant. 3.3V range. Medium speed."
io8_ft_ls_1v2  "General purpose IO. 5V tolerant. 1.2V range. Low speed."
io8_ft_ls_1v8  "General purpose IO. 5V tolerant. 1.8V range. Low speed."
io8_ft_ls_3v3  "General purpose IO. 5V tolerant. 3.3V range. Low speed."
io8_hslv_ft_hs_1v2  "General purpose IO with low voltage optimization. 5V tolerant. 1.2V range. High speed."
io8_hslv_ft_hs_1v8  "General purpose IO with low voltage optimization. 5V tolerant. 1.8V range. High speed."
io8_hslv_ft_hs_2v5  "General purpose IO with low voltage optimization. 5V tolerant. 2.5V range. High speed."
io8_hslv_ft_fs_1v2  "General purpose IO with low voltage optimization. 5V tolerant. 1.2V range. Fast speed."
io8_hslv_ft_fs_1v8  "General purpose IO with low voltage optimization. 5V tolerant. 1.8V range. Fast speed."
io8_hslv_ft_fs_2v5  "General purpose IO with low voltage optimization. 5V tolerant. 2.5V range. Fast speed."
io8_hslv_ft_ms_1v2  "General purpose IO with low voltage optimization. 5V tolerant. 1.2V range. Medium speed."
io8_hslv_ft_ms_1v8  "General purpose IO with low voltage optimization. 5V tolerant. 1.8V range. Medium speed."
io8_hslv_ft_ms_2v5  "General purpose IO with low voltage optimization. 5V tolerant. 2.5V range. Medium speed."
io8_hslv_ft_ls_1v2  "General purpose IO with low voltage optimization. 5V tolerant. 1.2V range. Low speed."
io8_hslv_ft_ls_1v8  "General purpose IO with low voltage optimization. 5V tolerant. 1.8V range. Low speed."
io8_hslv_ft_ls_2v5  "General purpose IO with low voltage optimization. 5V tolerant. 2.5V range. Low speed."
[Model Selector] io8_hslv_i2c_ft
io8_ft_hs_1v2  "General purpose IO. 5V tolerant. 1.2V range. High speed."
io8_ft_hs_1v8  "General purpose IO. 5V tolerant. 1.8V range. High speed."
io8_ft_hs_3v3  "General purpose IO. 5V tolerant. 3.3V range. High speed."
io8_ft_fs_1v2  "General purpose IO. 5V tolerant. 1.2V range. Fast speed."
io8_ft_fs_1v8  "General purpose IO. 5V tolerant. 1.8V range. Fast speed."
io8_ft_fs_3v3  "General purpose IO. 5V tolerant. 3.3V range. Fast speed."
io8_ft_ms_1v2  "General purpose IO. 5V tolerant. 1.2V range. Medium speed."
io8_ft_ms_1v8  "General purpose IO. 5V tolerant. 1.8V range. Medium speed."
io8_ft_ms_3v3  "General purpose IO. 5V tolerant. 3.3V range. Medium speed."
io8_ft_ls_1v2  "General purpose IO. 5V tolerant. 1.2V range. Low speed."
io8_ft_ls_1v8  "General purpose IO. 5V tolerant. 1.8V range. Low speed."
io8_ft_ls_3v3  "General purpose IO. 5V tolerant. 3.3V range. Low speed."
io8_hslv_ft_hs_1v2  "General purpose IO with low voltage optimization. 5V tolerant. 1.2V range. High speed."
io8_hslv_ft_hs_1v8  "General purpose IO with low voltage optimization. 5V tolerant. 1.8V range. High speed."
io8_hslv_ft_hs_2v5  "General purpose IO with low voltage optimization. 5V tolerant. 2.5V range. High speed."
io8_hslv_ft_fs_1v2  "General purpose IO with low voltage optimization. 5V tolerant. 1.2V range. Fast speed."
io8_hslv_ft_fs_1v8  "General purpose IO with low voltage optimization. 5V tolerant. 1.8V range. Fast speed."
io8_hslv_ft_fs_2v5  "General purpose IO with low voltage optimization. 5V tolerant. 2.5V range. Fast speed."
io8_hslv_ft_ms_1v2  "General purpose IO with low voltage optimization. 5V tolerant. 1.2V range. Medium speed."
io8_hslv_ft_ms_1v8  "General purpose IO with low voltage optimization. 5V tolerant. 1.8V range. Medium speed."
io8_hslv_ft_ms_2v5  "General purpose IO with low voltage optimization. 5V tolerant. 2.5V range. Medium speed."
io8_hslv_ft_ls_1v2  "General purpose IO with low voltage optimization. 5V tolerant. 1.2V range. Low speed."
io8_hslv_ft_ls_1v8  "General purpose IO with low voltage optimization. 5V tolerant. 1.8V range. Low speed."
io8_hslv_ft_ls_2v5  "General purpose IO with low voltage optimization. 5V tolerant. 2.5V range. Low speed."
io8_i2c_ft_1v2  "General purpose IO with I2C functionality. 5V tolerant. 1.2V range"
io8_i2c_ft_1v8  "General purpose IO with I2C functionality. 5V tolerant. 1.8V range"
io8_i2c_ft_3v3  "General purpose IO with I2C functionality. 5V tolerant. 3.3V range"
[Model Selector] io8_hslv_swp_ft
io8_ft_hs_1v2  "General purpose IO. 5V tolerant. 1.2V range. High speed."
io8_ft_hs_1v8  "General purpose IO. 5V tolerant. 1.8V range. High speed."
io8_ft_hs_3v3  "General purpose IO. 5V tolerant. 3.3V range. High speed."
io8_ft_fs_1v2  "General purpose IO. 5V tolerant. 1.2V range. Fast speed."
io8_ft_fs_1v8  "General purpose IO. 5V tolerant. 1.8V range. Fast speed."
io8_ft_fs_3v3  "General purpose IO. 5V tolerant. 3.3V range. Fast speed."
io8_ft_ms_1v2  "General purpose IO. 5V tolerant. 1.2V range. Medium speed."
io8_ft_ms_1v8  "General purpose IO. 5V tolerant. 1.8V range. Medium speed."
io8_ft_ms_3v3  "General purpose IO. 5V tolerant. 3.3V range. Medium speed."
io8_ft_ls_1v2  "General purpose IO. 5V tolerant. 1.2V range. Low speed."
io8_ft_ls_1v8  "General purpose IO. 5V tolerant. 1.8V range. Low speed."
io8_ft_ls_3v3  "General purpose IO. 5V tolerant. 3.3V range. Low speed."
io8_hslv_ft_hs_1v2  "General purpose IO with low voltage optimization. 5V tolerant. 1.2V range. High speed."
io8_hslv_ft_hs_1v8  "General purpose IO with low voltage optimization. 5V tolerant. 1.8V range. High speed."
io8_hslv_ft_hs_2v5  "General purpose IO with low voltage optimization. 5V tolerant. 2.5V range. High speed."
io8_hslv_ft_fs_1v2  "General purpose IO with low voltage optimization. 5V tolerant. 1.2V range. Fast speed."
io8_hslv_ft_fs_1v8  "General purpose IO with low voltage optimization. 5V tolerant. 1.8V range. Fast speed."
io8_hslv_ft_fs_2v5  "General purpose IO with low voltage optimization. 5V tolerant. 2.5V range. Fast speed."
io8_hslv_ft_ms_1v2  "General purpose IO with low voltage optimization. 5V tolerant. 1.2V range. Medium speed."
io8_hslv_ft_ms_1v8  "General purpose IO with low voltage optimization. 5V tolerant. 1.8V range. Medium speed."
io8_hslv_ft_ms_2v5  "General purpose IO with low voltage optimization. 5V tolerant. 2.5V range. Medium speed."
io8_hslv_ft_ls_1v2  "General purpose IO with low voltage optimization. 5V tolerant. 1.2V range. Low speed."
io8_hslv_ft_ls_1v8  "General purpose IO with low voltage optimization. 5V tolerant. 1.8V range. Low speed."
io8_hslv_ft_ls_2v5  "General purpose IO with low voltage optimization. 5V tolerant. 2.5V range. Low speed."
io8_hslv_swpc_ft  "GP IO with low voltage opt. and SWP C functionality. 5V tolerant. 1.8V range"
io8_hslv_swpb_ft  "GP IO with low voltage opt. and SWP B functionality. 5V tolerant. 3.3V range"
[Model Selector] io8_i2c_ft
io8_ft_hs_1v2  "General purpose IO. 5V tolerant. 1.2V range. High speed."
io8_ft_hs_1v8  "General purpose IO. 5V tolerant. 1.8V range. High speed."
io8_ft_hs_3v3  "General purpose IO. 5V tolerant. 3.3V range. High speed."
io8_ft_fs_1v2  "General purpose IO. 5V tolerant. 1.2V range. Fast speed."
io8_ft_fs_1v8  "General purpose IO. 5V tolerant. 1.8V range. Fast speed."
io8_ft_fs_3v3  "General purpose IO. 5V tolerant. 3.3V range. Fast speed."
io8_ft_ms_1v2  "General purpose IO. 5V tolerant. 1.2V range. Medium speed."
io8_ft_ms_1v8  "General purpose IO. 5V tolerant. 1.8V range. Medium speed."
io8_ft_ms_3v3  "General purpose IO. 5V tolerant. 3.3V range. Medium speed."
io8_ft_ls_1v2  "General purpose IO. 5V tolerant. 1.2V range. Low speed."
io8_ft_ls_1v8  "General purpose IO. 5V tolerant. 1.8V range. Low speed."
io8_ft_ls_3v3  "General purpose IO. 5V tolerant. 3.3V range. Low speed."
io8_i2c_ft_1v2  "General purpose IO with I2C functionality. 5V tolerant. 1.2V range"
io8_i2c_ft_1v8  "General purpose IO with I2C functionality. 5V tolerant. 1.8V range"
io8_i2c_ft_3v3  "General purpose IO with I2C functionality. 5V tolerant. 3.3V range"
[Model Selector] io8usb_id_otg20_ft
io8_ft_hs_1v2  "General purpose IO. 5V tolerant. 1.2V range. High speed."
io8_ft_hs_1v8  "General purpose IO. 5V tolerant. 1.8V range. High speed."
io8_ft_hs_3v3  "General purpose IO. 5V tolerant. 3.3V range. High speed."
io8_ft_fs_1v2  "General purpose IO. 5V tolerant. 1.2V range. Fast speed."
io8_ft_fs_1v8  "General purpose IO. 5V tolerant. 1.8V range. Fast speed."
io8_ft_fs_3v3  "General purpose IO. 5V tolerant. 3.3V range. Fast speed."
io8_ft_ms_1v2  "General purpose IO. 5V tolerant. 1.2V range. Medium speed."
io8_ft_ms_1v8  "General purpose IO. 5V tolerant. 1.8V range. Medium speed."
io8_ft_ms_3v3  "General purpose IO. 5V tolerant. 3.3V range. Medium speed."
io8_ft_ls_1v2  "General purpose IO. 5V tolerant. 1.2V range. Low speed."
io8_ft_ls_1v8  "General purpose IO. 5V tolerant. 1.8V range. Low speed."
io8_ft_ls_3v3  "General purpose IO. 5V tolerant. 3.3V range. Low speed."
io8usb_id_ft_pup  "USB OTG ID PAD. 5V tolerant. With pull up"
io8usb_id_ft_nopup  "USB OTG ID PAD. 5V tolerant. No pull up"
[Model Selector] io8usb_lsfs_bcd_otg20_ft
io8_ft_hs_1v2  "General purpose IO. 5V tolerant. 1.2V range. High speed."
io8_ft_hs_1v8  "General purpose IO. 5V tolerant. 1.8V range. High speed."
io8_ft_hs_3v3  "General purpose IO. 5V tolerant. 3.3V range. High speed."
io8_ft_fs_1v2  "General purpose IO. 5V tolerant. 1.2V range. Fast speed."
io8_ft_fs_1v8  "General purpose IO. 5V tolerant. 1.8V range. Fast speed."
io8_ft_fs_3v3  "General purpose IO. 5V tolerant. 3.3V range. Fast speed."
io8_ft_ms_1v2  "General purpose IO. 5V tolerant. 1.2V range. Medium speed."
io8_ft_ms_1v8  "General purpose IO. 5V tolerant. 1.8V range. Medium speed."
io8_ft_ms_3v3  "General purpose IO. 5V tolerant. 3.3V range. Medium speed."
io8_ft_ls_1v2  "General purpose IO. 5V tolerant. 1.2V range. Low speed."
io8_ft_ls_1v8  "General purpose IO. 5V tolerant. 1.8V range. Low speed."
io8_ft_ls_3v3  "General purpose IO. 5V tolerant. 3.3V range. Low speed."
io8usb_fs_ft_pu2  ""USB full speed + pull up2""
io8usb_fs_ft_pu1  ""USB full speed + pull up1""
io8usb_fs_ft_pd  ""USB full speed + pull down""
io8usb_fs_ft  ""USB full speed""
io8usb_ls_ft_pu2  ""USB low speed + pull up2""
io8usb_ls_ft_pu1  ""USB low speed + pull up1""
io8usb_ls_ft_pd  ""USB low speed + pull down""
io8usb_ls_ft  ""USB low speed""
[Model Selector] io8usb_vbus_otg20_ft
io8_ft_hs_1v2  "General purpose IO. 5V tolerant. 1.2V range. High speed."
io8_ft_hs_1v8  "General purpose IO. 5V tolerant. 1.8V range. High speed."
io8_ft_hs_3v3  "General purpose IO. 5V tolerant. 3.3V range. High speed."
io8_ft_fs_1v2  "General purpose IO. 5V tolerant. 1.2V range. Fast speed."
io8_ft_fs_1v8  "General purpose IO. 5V tolerant. 1.8V range. Fast speed."
io8_ft_fs_3v3  "General purpose IO. 5V tolerant. 3.3V range. Fast speed."
io8_ft_ms_1v2  "General purpose IO. 5V tolerant. 1.2V range. Medium speed."
io8_ft_ms_1v8  "General purpose IO. 5V tolerant. 1.8V range. Medium speed."
io8_ft_ms_3v3  "General purpose IO. 5V tolerant. 3.3V range. Medium speed."
io8_ft_ls_1v2  "General purpose IO. 5V tolerant. 1.2V range. Low speed."
io8_ft_ls_1v8  "General purpose IO. 5V tolerant. 1.8V range. Low speed."
io8_ft_ls_3v3  "General purpose IO. 5V tolerant. 3.3V range. Low speed."
io8usb_adp  "USB Adp no pull up, no pull down"
io8usb_vbus  "USB Vbus"
[Model Selector] ioreset_ft
ioreset_ft_v33_pu_1v2  "Reset PAD - PU on. 5V tolerant. 1.2V range"
ioreset_ft_v33_pu_1v8  "Reset PAD - PU on. 5V tolerant. 1.8V range"
ioreset_ft_v33_pu_3v3  "Reset PAD - PU on. 5V tolerant. 3.3V range"
ioreset_ft_v33_1v2  "Reset PAD. 5V tolerant. 1.2V range"
ioreset_ft_v33_1v8  "Reset PAD. 5V tolerant. 1.8V range"
ioreset_ft_v33_3v3  "Reset PAD. 5V tolerant. 3.3V range"
[Model Selector] vpp_test_hv
vpp_1v2  "Vpp 1V2 range"
vpp_1v8  "Vpp 1v8 range"
vpp_3v3  "Vpp 3V3 range"
| Models and submodels in the file (50): io8_ft_hs_1v2 (I/O), io8_ft_hs_1v8 (I/O), io8_ft_hs_3v3 (I/O), io8_ft_fs_1v2 (I/O), io8_ft_fs_1v8 (I/O), io8_ft_fs_3v3 (I/O), io8_ft_ms_1v2 (I/O), io8_ft_ms_1v8 (I/O), io8_ft_ms_3v3 (I/O), io8_ft_ls_1v2 (I/O), io8_ft_ls_1v8 (I/O), io8_ft_ls_3v3 (I/O), io8_hslv_ft_hs_1v2 (I/O), io8_hslv_ft_hs_1v8 (I/O), io8_hslv_ft_hs_2v5 (I/O), io8_hslv_ft_fs_1v2 (I/O), io8_hslv_ft_fs_1v8 (I/O), io8_hslv_ft_fs_2v5 (I/O), io8_hslv_ft_ms_1v2 (I/O), io8_hslv_ft_ms_1v8 (I/O), io8_hslv_ft_ms_2v5 (I/O), io8_hslv_ft_ls_1v2 (I/O), io8_hslv_ft_ls_1v8 (I/O), io8_hslv_ft_ls_2v5 (I/O), io8_hslv_swpc_ft (I/O), io8_hslv_swpb_ft (I/O), io8_i2c_ft_1v2 (I/O), io8_i2c_ft_1v8 (I/O), io8_i2c_ft_3v3 (I/O), io8usb_id_ft_pup (Input), io8usb_id_ft_nopup (Input), io8usb_fs_ft_pu2 (I/O), io8usb_fs_ft_pu1 (I/O), io8usb_fs_ft_pd (I/O), io8usb_fs_ft (I/O), io8usb_ls_ft_pu2 (I/O), io8usb_ls_ft_pu1 (I/O), io8usb_ls_ft_pd (I/O), io8usb_ls_ft (I/O), io8usb_adp (I/O), io8usb_vbus (I/O), ioreset_ft_v33_pu_1v2 (I/O_open_drain), ioreset_ft_v33_pu_1v8 (I/O_open_drain), ioreset_ft_v33_pu_3v3 (I/O_open_drain), ioreset_ft_v33_1v2 (I/O_open_drain), ioreset_ft_v33_1v8 (I/O_open_drain), ioreset_ft_v33_3v3 (I/O_open_drain), vpp_1v2 (Input), vpp_1v8 (Input), vpp_3v3 (Input)
